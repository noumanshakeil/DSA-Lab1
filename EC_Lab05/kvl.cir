* EC Lab05 KVL circuit Vs=5V R5=1.5k
* Nodes: a=N001 b=N002 c=N003 d=N004 e=N005 f=0
Vs N001 0 5
R1 N001 N002 1k
R2 N002 N005 2.2k
R3 N002 N003 1.8k
R4 N003 N004 1k
R5 N004 N005 1.5k
R6 N005 0 2.7k
.op
.end
